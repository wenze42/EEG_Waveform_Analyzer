* Experiment 2 -- Common-Emitter Amplifier (LTspice compatible netlist)
* Vcc = 9V, R1 = 56k, R2 = 15k, R3 = 2k, R4 = 1k, RL = 2k
* C1 = C3 = 10uF, C2 = 100uF, Q1 = 9013 (NPN)
* Run: open this file in LTspice (File type: All files) and press Run
Vcc 1 0 9
Vin 2 0 AC 1 SINE(0 9.75m 1k)
C1 2 3 10u
R1 1 3 56k
R2 3 0 15k
Q1 4 3 5 NPN1
R3 1 4 2k
R4 5 0 1k
C2 5 0 100u
C3 4 6 10u
RL 6 0 2k
CL 6 0 220p
.model NPN1 NPN(BF=100 IS=1e-14 VAF=100 RB=100 RC=10 RE=1 CJE=25p CJC=6p TF=0.35n)
.op
.tran 1u 6m 0 1u
.ac dec 60 1 10meg
.meas tran Ui_pp PP V(3) FROM=4m TO=6m
.meas tran Uo_pp PP V(6) FROM=4m TO=6m
.end

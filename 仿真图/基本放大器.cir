* 分压式偏置单管共射放大器 — 实验二
Vcc  1  0  DC 9
Vin  2  0  AC 1  SINE(0 9.75m 1k)
C1   2  3  10u
R1   1  3  56k
R2   3  0  15k
Q1   4  3  5  NPN1
R3   1  4  2k
R4   5  0  1k
C2   5  0  100u
C3   4  6  10u
RL   6  0  2k
.model NPN1 NPN(BF=100 IS=1e-14 VAF=100 RB=100 RC=10 RE=1)

.op
.tran 1u 4m 0 1u
.ac dec 50 1 10meg

.print tran v(3) v(6)
.print ac vm(6) vp(6)
.end
